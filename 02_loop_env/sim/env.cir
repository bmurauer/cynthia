* ---------- #02 loop envelope: OTA slew core ----------
* Driven by run.py, which replaces the .param line below.
*   XA, XR : attack / release pot rotation, 0 = CCW (fast) .. 1 = CW (slow)
*   SHAPE  : shape pot rotation, 0 = CCW (exponential) .. 1 = CW (linear)
*   MODE   : 0 = gate, 1 = loop
*   CVA/CVR: attack / release CV in volts (+ = faster)
*   VOS    : LM13700 input offset (datasheet max 4mV)
*   VP     : rail voltage (+/-), SAT: TL07x output swing (+/-)
*   TG, TP : gate pulse width / period
.include core.lib
.param SAT=9.6 VP=11.5 VOS=0 XA=0.5 XR=0.5 SHAPE=0 MODE=0 CVA=0 CVR=0 TG=1 TP=100
VP vp 0 {VP}
VN vn 0 {-VP}
* --- time channels: inverting summer -> base divider -> matched PNP pair (BCM857BS)
* pair: common emitter with tail current from +12V, Q1 collector -> I_ABC,
* Q2 (base GND) dumps the rest to GND. I_ABC = I_tail / (1 + exp(Vbase/Vt)),
* so I_ABC can never exceed I_tail (~1.45mA), whatever the CV does.
* pot B10k GND(ccw) .. VN(cw)
* --- attack ---
Rpa1 0 wa {max(10k*XA,1)}
Rpa2 wa vn {max(10k*(1-XA),1)}
Rina wa sa 100k
Rcva cva sa 100k
Vcva cva 0 {CVA}
Roffa vp sa 1.5Meg
Rfa sa suma 82k
XUa 0 sa suma OPA
Rb1a suma ba 15k
Rb2a ba 0 510
Rta_tail vp ea 7.5k
Qa1 abc ba ea BC857
Qa2 0 0 ea BC857
* --- release ---
Rpr1 0 wr {max(10k*XR,1)}
Rpr2 wr vn {max(10k*(1-XR),1)}
Rinr wr sr 100k
Rcvr cvr sr 100k
Vcvr cvr 0 {CVR}
Roffr vp sr 1.5Meg
Rfr sr sumr 82k
XUr 0 sr sumr OPA
Rb1r sumr br 15k
Rb2r br 0 510
Rtr_tail vp er 7.5k
Qr1 abc br er BC857
Qr2 0 0 er BC857
* --- stage enables (S = stage signal, high = rising): S high -> kill release; S low -> (inverter) kill attack ---
Dkr s kr D4148
Rkr kr br 10k
Rqi1 s qib 100k
Rqi2 qib 0 22k
Qinv sbar qib 0 BC847
Rsbar vp sbar 4.7k
Dka sbar ka D4148
Rka ka ba 4.7k
* --- target network (Thevenin 10k) + shape pot between OTA inputs ---
Rta s np 39k
Rtb vp np 56k
Rtc np 0 18k
* A5k (log taper, ~10% at mid rotation) as rheostat + 220R
Rsh np nn {220 + 5k*(pow(100,SHAPE)-1)/99}
R2 nn capb 10k
XOTA np nn ct abc OTA
CT ct 0 100n
* --- cap buffer, precision clamp at 0V ---
XUbuf ct capb capb OPA
XUcl 0 ct ucl OPA
* clamp diode: BAS416 (low leakage)
Dcl ucl ct DLL
* --- output x2 ---
XUo capb fbo out OPA
Rfo1 out fbo 10k
Rfo2 fbo 0 10k
* --- gate input comparator ---
Vgate gin 0 PULSE(0 5 5m 1u 1u {TG} {TP})
Rgi gin gp 100k
Rgf g gp 2.2Meg
Rgr1 vp gref 100k
Rgr2 gref 0 9.1k
XUg gp gref g OPA
* --- cycle Schmitt: Q high when cap < THlo, low when cap > THhi ---
Rxs capb x 10k
Rq q th 150k
Rp vp th 160k
Rg th 0 47k
XUs th x q OPA
* gate mode: gate high forces Q low (EOC fires at end of release)
Dfg g fg D4148
Rfg fg xf 10k
Rmf xf x {1 + 1e12*MODE}
* --- mode: S = G (gate) or Q (loop) ---
Rsg g s {1 + 1e12*MODE}
Rsq q s {1 + 1e12*(1-MODE)}
.ic V(ct)=0
.options reltol=1e-4 method=gear maxord=2
